* Option 2 Simulation: High-Side VCCS (Op-Amp + P-MOSFET + Single Sense Resistor)
* Target current: 200uA Biphasic Pulse into Variable Skin Load (1k to 50k)
*
* Boost Voltage Rail: 20V
Vboost VBOOST 0 DC 20

* Control Voltage: V_ctrl = 19.8V => Delta_V on R_sense = 20V - 19.8V = 0.2V
* I_target = 0.2V / 1k = 200uA
Vctrl VCTRL 0 PULSE(20 19.8 0 10u 10u 24.9m 50m)

* High-Side Current Source:
* R_sense is a single precision resistor (1k ohm, 0.1%)
Rsense VBOOST SENSE_NODE 1k

* Op-Amp maintains V(SENSE_NODE) = V(VCTRL)
* Non-inverting input connects to VCTRL, inverting input connects to SENSE_NODE
E_OPAMP GATE_P 0 VCTRL SENSE_NODE 100000

* P-Channel MOSFET:
* Source = SENSE_NODE, Gate = GATE_P, Drain = IOUT
M1 IOUT GATE_P SENSE_NODE SENSE_NODE PMOS_IDEAL
.model PMOS_IDEAL PMOS (Vto=-1.5 Kp=10m)

* Load Model: Stepping skin resistance across 1k, 10k, 25k, 50k
.param Rskin_val=10k
Rload IOUT 0 {Rskin_val}

* Simulation command:
.tran 0 100m 0 10u
.step param Rskin_val list 1k 10k 25k 50k

.end
