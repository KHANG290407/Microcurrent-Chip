* Howland Current Pump with Biological Skin Load (Randles / Cole-Cole Model)
* Target current: 200uA Biphasic Pulse @ 20Hz
*
Vp VCC 0 DC 20
Vn VEE 0 DC -20

* Input: 2V Peak => I_load = 2V / 10k = 200uA
Vin IN 0 PULSE(-2 2 0 10u 10u 24.9m 50m)

* Howland Bridge 10k (0.1% tolerance)
R1 IN N_INV 10k
R2 N_INV VOUT 10k
R3 0 NON_INV 10k
R4 NON_INV VOUT 10k

* Biological Skin Equivalent Model between NON_INV and GND:
* C_sc: Capacitance of stratum corneum (~10nF)
* R_sc: Resistance of stratum corneum (Dry = 50k, Moist = 5k)
* R_deep: Deep tissue / interstitial fluid resistance (~300 ohms)
.param R_sc_val=20k
C_sc NON_INV NODE_DEEP 10n
R_sc NON_INV NODE_DEEP {R_sc_val}
R_deep NODE_DEEP 0 300

* Op-Amp (VCVS high gain)
E_AMP VOUT 0 NON_INV N_INV 200000

* Simulation Commands:
.tran 0 100m 0 10u
.step param R_sc_val list 2k 10k 25k 50k

.end
